* TB1: power sequence - ACC on, MCU boot, cranking, ACC off, MCU release
*  Scenario (s): 0 parked | 1 ACC on | 1.5 MCU drives HOLD=H | 3.0-4.0 cranking
*  (ACC cut, VBAT 7V/50ms then 9V) | 8 ACC off (shutdown) | 12 MCU drives HOLD=L
*  Set .param MCUFAIL=1 to simulate the MCU dying (pin Hi-Z) at 12 s instead.
.include models.lib
.param MCUFAIL=0
* ---- battery + harness ----
Vbat vb0 0 PWL(0 12.6  3 12.6  3.001 7  3.05 7  3.06 9  4.0 9  4.1 14.2  30 14.2)
* battery internal R + harness (2m of 2sq wire ~ 20mohm, ~1uH)
Rbat vb0 vb1 0.03
Lharn vb1 vbat 1u
Racc_on vbat accsw 0.05
* ACC switch: on 1..3, off during crank 3..4, on 4..8, off after 8
Vaccctl accctl 0 PWL(0 0 0.999 0 1 5 2.999 5 3 0 3.999 0 4 5 7.999 5 8 0)
Sacc accsw acc accctl 0 SWACC
.model SWACC SW(Vt=2.5 Vh=0.1 Ron=0.05 Roff=1e7)
Cacc acc 0 100n
* ACC line when the key is off: pulled down by the car's ACC loads (radio etc.)
Racc_leak acc 0 1k
* on-board ACC sense divider R5 47k / R6 6.8k (v1.8)
R5 acc accs 47k
R6 accs 0 6.8k
C12 accs 0 100n
* ---- relay & 7A path ----
XK1 coilp coiln vbat vsw G2RLV
XTVS1 0 vsw DSM8S20A_SUB
.subckt DSM8S20A_SUB A K
D1 A K DSM8S20A
.ends
C1 vsw c1n 100u ic=0
Rc1 c1n 0 0.3
C2 vsw 0 10u
C3 vsw 0 10u
* LED1 (red) + R40 4.7k on VSW
R40 vsw led1 4.7k
DLED1 led1 0 DLEDR
XDFR vsw 0 DFRLOAD PARAMS: PLOAD=67 CIN=440u
* ---- v2.0 sensor supply on VSW_EXT (F4 -> U8 5VS -> U9 3V3S), 0.3 A on 5VS + 0.4 A on 3V3S ----
XSEN vsw vswext v5s v3s 0 SENSORSUP
* ---- ACC TVS ----
DTVS2 0 acc DSMAJ20A
* ---- 5V aux supply ----
D7 vsw vin5 DSS34
D9 acc vin5 DSS34
C4 vin5 0 470u
C5 vin5 0 1u
XU1 vin5 v5reg 0 XL7015AVG
C6 v5reg 0 100u
D8 v5reg v5 DSS34
C9 v5 0 10u
XLOAD v5 0 XIAOLOAD
* XIAO on-board LDO 3V3 (dropout ~0.25V) + 3V3 loads (~30mA)
B3v3 v3i 0 V = min(3.3, max(V(v5)-0.25,0))
R3v3 v3i v3v3 0.2
C13 v3v3 0 10u
Rl3 v3v3 0 110
* ---- relay coil drive ----
D1 acc coilp D1N4148
D2 vsw coilp D1N4148
D5 coiln coilp D1N4148
M1 coiln holdg 0 0 NBSS138
R11 holdg 0 100k
XU5 holdn holdg v3v3 0 LVC1G17
C10 v3v3 0 100n
* ---- HOLD node ----
D3 acc accd D1N4148
R3 accd holdn 470k
R1 holdpin holdn 1k
C11 holdn 0 10u ic=0
R2 holdn 0 1Meg
DZ1 0 holdn DZ3V6
* ---- MCU pin model: H (3.3V via 50ohm) / L (via 50ohm) / Hi-Z, only while 3V3 > 3.0V
Vhctl hctl 0 PWL(0 0  1.499 0  1.5 5  11.999 5  12 0)
Vlctl lctl 0 PWL(0 0  11.999 0  12 {5*(1-MCUFAIL)}  30 {5*(1-MCUFAIL)})
Bh hen 0 V = (V(hctl)>2.5 && V(v3v3)>3.0) ? 5 : 0
Bl len 0 V = (V(lctl)>2.5 && V(v3v3)>3.0) ? 5 : 0
SH v3v3 holdpin hen 0 SWPIN
SL holdpin 0 len 0 SWPIN
.model SWPIN SW(Vt=2.5 Vh=0.1 Ron=50 Roff=1e9)
.options method=gear reltol=1e-3 itl4=100
.tran 1m 24 0 2m uic
.control
run
let ivsw = -i(vbat)
meas tran t_relay_on WHEN v(vsw)=6 RISE=1
meas tran vsw_min_crank MIN v(vsw) FROM=3 TO=4.2
meas tran v5_min_crank MIN v(v5) FROM=3 TO=4.2
meas tran v3_min_all MIN v(v3v3) FROM=1.6 TO=11.9
meas tran holdn_crank MIN v(holdn) FROM=3 TO=4.2
meas tran t_relay_off WHEN v(vsw)=6 FALL=LAST
meas tran ibat_peak MAX ivsw FROM=1.2 TO=1.6
meas tran v5s_min_crank MIN v(v5s) FROM=3 TO=4.2
meas tran v3s_min_crank MIN v(v3s) FROM=3 TO=4.2
meas tran v5s_on AVG v(v5s) FROM=2 TO=2.9
meas tran v3s_on AVG v(v3s) FROM=2 TO=2.9
wrdata tb1_out.txt v(acc) v(vbat) v(vsw) v(v5) v(v3v3) v(holdn) v(holdg) v(coilp,coiln) ivsw v(v5s) v(v3s)
.endc
.end
