* TB5: inrush when K1 closes into the VSW capacitors + DFR0946 input capacitors
*  C1 100uF (ESR 0.3) + C2/C3 10uF ceramic + DFR0946 input (assumed 440uF, ESR 30 mohm).
*  The harness resistance / inductance dominate the result: change RH / LH to your wiring.
*  Checks: peak contact current, I^2t, settle time.  (G2RL-1A-E: 16 A rated, no inrush rating
*  published -> compare with the DFR0946 input fuse / connector, and keep I^2t small.)
.include models.lib
.param RH=0.03 LH=1u CDFR=440u
Vbat vb0 0 12.6
Rh vb0 vb1 {RH}
Lh vb1 vbat {LH}
* contact closes at 10 ms (bounce not modelled)
Vk kctl 0 PWL(0 0 10m 0 10.001m 5)
Sk vbat vk kctl 0 SWK
.model SWK SW(Vt=2.5 Vh=0.1 Ron=0.01 Roff=1e8)
Vi_k vk vsw 0
C1 vsw c1n 100u
Rc1 c1n 0 0.3
C2 vsw c2n 10u
Rc2 c2n 0 5m
C3 vsw c3n 10u
Rc3 c3n 0 5m
* 2 m of Mini-Fit harness to the DFR0946 (~10 mohm, 0.5 uH)
Rw vsw vw1 10m
Lw vw1 vdfr 0.5u
XDFR vdfr 0 DFRLOAD PARAMS: PLOAD=67 CIN={CDFR} ESR=0.03
* ---- v2.0: on-board converters charge at the same moment ----
* MCU 5V buck input: D7 -> C4 470uF (ESR 0.08) + C5 1uF
Vi_d7 vsw d7a 0
D7 d7a vin5 DSS34
C4 vin5 c4n 470u
Rc4 c4n 0 0.08
C5 vin5 0 1u
* sensor supply input: F4 (PTC, ~0.15 ohm cold) -> C40 100uF (ESR 0.3) + C41 10uF (v2.4.1, nominal value: worst case for inrush)
Vi_f4 vsw f4a 0
Rf4 f4a vswext 0.15
C40 vswext c40n 100u
Rc40 c40n 0 0.3
C41 vswext 0 10u
.options method=gear
.tran 1u 30m 0 1u
.control
run
let ik = i(vi_k)
let ik2 = ik*ik
let i2t = integ(ik2)
meas tran i_peak MAX ik
meas tran i_d7_peak MAX i(vi_d7)
meas tran i_f4_peak MAX i(vi_f4)
let if42 = i(vi_f4)*i(vi_f4)
let i2t_f4 = integ(if42)
meas tran i2t_f4_total FIND i2t_f4 AT=30m
meas tran i2t_total FIND i2t AT=30m
meas tran t_settle WHEN v(vdfr)=11.9 RISE=1
let tset_ms = (t_settle-10m)*1000
print tset_ms
wrdata tb5_out.txt ik v(vsw) v(vdfr) i(vi_d7) i(vi_f4)
.endc
.end
