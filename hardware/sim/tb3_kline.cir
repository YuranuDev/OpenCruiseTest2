* TB3: K-line (ISO 14230) drive - fast init, 5-baud init, 10400 bps bytes
*  .param PAR=0 : JP6 only (TJA1021 alone)       -> 5-baud bit (200 ms) is cut at ~27 ms
*  .param PAR=1 : JP6 + JP7 (parallel, Q9 holds) -> K stays low for the whole bit
*  Timeline: 0-0.3 s idle | 0.3 s fast init 25 ms L / 25 ms H | 0.40 s two bytes 0xC1 0x33
*            at 10400 bps | 0.6 s 5-baud init address 0x33 (start + 8 bits + stop, 200 ms each)
.include models.lib
.param PAR=1
.param ECU_PU=1k
* ---- supply ----
Vvsw vsw 0 13.8
V3 v3v3 0 3.3
* ---- MCU TX pin (KL_TXS): idle high, PWL below ----
Btx txpin 0 V = 3.3*V(txlogic)
Vtxl txlogic 0 PWL(0 1 0.3 1 0.300001 0 0.325 0 0.325001 1 0.4 1 0.400001 0 0.4000962 0 0.4000972 1
+ 0.4001923 1 0.4001933 0 0.4006731 0 0.4006741 1 0.4011538 1 0.4011548 0 0.40125 0 0.401251 1 0.4014423 1
+ 0.4014433 0 0.4016346 0 0.4016356 1 0.4018269 1 0.4018279 0 0.4020192 0 0.4020202 1 0.6 1 0.600001 0 0.8 0
+ 0.800001 1 1.2 1 1.200001 0 1.6 0 1.600001 1 2 1 2.000001 0 2.4 0 2.400001 1 2.9 1)
Rtx txpin kl_txs 100
R73 v3v3 kl_txs 10k
* ---- JP6: KL_TXS -> KL_TXD (TJA TXD), R72 pull-up ----
Rjp6 kl_txs kl_txd 0.01
R72 v3v3 kl_txd 10k
XU4 kl_txd kl_rxd kline vsw 0 TJA1021
R70 v3v3 kl_rxd 4.7k
* ---- K pull-up: D10 + R14 510R, TVS3, (C17 220p) ----
D10 vsw kpu D1N4148
R14 kpu kline 510
DTVS3 0 kline DSMAJ24A
C17 kline 0 220p
* ---- parallel direct driver: R20/R21/Q8, R22, JP7, R23/Q9, F3 ----
R20 kl_txs kdrv_b 10k
R21 kdrv_b 0 100k
Q8 kdrv kdrv_b 0 QMMBT3904
R22 v3v3 kdrv 10k
Rjp7 kdrv kgate {0.01+(1-PAR)*1e9}
R23 kgate 0 100k
M9 kdrn kgate 0 0 N2N7002K
* F3 nSMD010 PTC ~ 3.5 ohm cold
RF3 kdrn kline 3.5
* ---- harness + ECU: 2 m cable (~200 pF), ECU pull-up and input capacitance ----
Rcab kline kecu 1
Cecu kecu 0 1n
Recu vsw kecu {ECU_PU}
.tran 2u 2.9 0 20u
.control
run
meas tran k_fast_low   AVG v(kline) FROM=0.305 TO=0.324
meas tran k_bit_early  AVG v(kline) FROM=0.61 TO=0.62
meas tran k_bit_late   AVG v(kline) FROM=0.75 TO=0.79
meas tran k_idle       AVG v(kline) FROM=0.1 TO=0.29
meas tran t_fall WHEN v(kline)=10 FALL=1 FROM=0.4
meas tran t_fall2 WHEN v(kline)=3 FALL=1 FROM=0.4
meas tran t_rise WHEN v(kline)=3 RISE=1 FROM=0.400096
meas tran t_rise2 WHEN v(kline)=10 RISE=1 FROM=0.400096
let fall_us = (t_fall2 - t_fall)*1e6
let rise_us = (t_rise2 - t_rise)*1e6
print fall_us rise_us
* note: TJA1021 edge slope is not modelled in detail (real part ~ 5-20 us), only the levels / timeout
meas tran rxd_bit_late AVG v(kl_rxd) FROM=0.75 TO=0.79
let pr14 = (v(kpu)-v(kline))*(v(kpu)-v(kline))/510
meas tran p_r14_low AVG pr14 FROM=0.61 TO=0.79
wrdata tb3_out.txt v(kl_txs) v(kline) v(kl_rxd) v(kgate)
.endc
.end
