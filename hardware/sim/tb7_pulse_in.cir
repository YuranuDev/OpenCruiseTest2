* TB7: pulse input adapter (PULSE-IN, 1 channel) -> XIAO D2/D3
*  Source: push-pull square wave (VHI, VLO, F) or open collector (OC=1) pulled up by R1 (PU = 5 or 12 V)
*  Front end: R2 22k -> SIG_A ; C1 1nF, D1 BZT52C4V7, (R3 10k via JP2 = "12V threshold")
*            -> U1 74LVC1G17 @ 3.3V (LDO) -> R4 100R -> cable -> MCU pin
*  Checks: output toggles every edge (no missing / extra pulses), delay, duty, clamp voltage.
.include models.lib
.param F=200 VHI=12 VLO=0.8 OC=0 PU=12 JP2=0 SPIKE=0
* ---- source (2 m of wire ~ 200 pF) ----
Bnrm nrm 0 V = (V(sq)-{VLO})/({VHI}-{VLO})
Vsq sq 0 PULSE({VLO} {VHI} 0 {0.02/F} {0.02/F} {0.5/F} {1/F})
* push-pull driver with 100 ohm output impedance (OC=0)
Rsrc sq sigin {100 + OC*1e9}
* open collector: transistor pulls low when sq is low, pull-up R1 4.7k to PU
Soc sigin 0 sqi 0 SWOC
Bsqi sqi 0 V = {OC}*({VHI}-V(sq))
.model SWOC SW(Vt={VHI/2} Vh=0.1 Ron=20 Roff=1e9)
R1 pu sigin {4.7k + (1-OC)*1e9}
Vpu pu 0 {PU}
Ccab sigin 0 200p
* optional 40 V / 1 ms spike while the input is high (clamp test; a spike in the low phase would be a real extra pulse)
Vsp spk 0 PULSE(0 40 0.5m 10u 100u 1m 1)
Rsp spk spk2 {10 + (1-SPIKE)*1e9}
Dsp spk2 sigin D1N4148
* ---- adapter ----
R2 sigin siga 22k
C1 siga 0 1n
DZ1 0 siga DZ4V7
R3 siga 0 {10k + (1-JP2)*1e9}
V33 v33 0 3.3
XU1 siga y v33 0 LVC1G17
R4 y out 100
* cable to main board + XIAO pin (~100 pF + 10 pF)
Cout out 0 110p
.model DZ4V7 D(Is=1e-14 Rs=20 N=1.0 bv=4.6 ibv=1m nbv=1.3 Cjo=100p)
.tran {0.002/F} {6/F} 0 {0.002/F}
.control
run
meas tran siga_max MAX v(siga)
meas tran siga_min MIN v(siga)
meas tran out_hi MAX v(out)
meas tran out_lo MIN v(out)
meas tran t_a WHEN v(out)=1.65 RISE=3
meas tran t_b WHEN v(out)=1.65 RISE=4
meas tran t_c WHEN v(out)=1.65 FALL=3
let f_out = 1/(t_b - t_a)
let duty = (t_c - t_a)/(t_b - t_a)
print f_out duty
wrdata tb7_out.txt v(sigin) v(siga) v(out)
.endc
.end
